* +++++++++++++++++++++++++++++++++++++++++++++++++++++++++ *
* CDL Netlist:                                              *
*                                                           *
* Cell Name  : RFReg                                        *
* Netlisted  : Fri Apr 24 22:23:46 2026                     *
* Pegasus Version: 23.23-s012 Wed May 29 16:54:16 PDT 2024  *
* +++++++++++++++++++++++++++++++++++++++++++++++++++++++++ *
*.LDD
*.DEVTMPLT 0 MN(g45n1svt) _nmos1v ndiff_conn(D) poly_conn(G) ndiff_conn(S) psubstrate(B)
*.DEVTMPLT 1 MP(g45p1svt) _pmos1v pdiff_conn(D) poly_conn(G) pdiff_conn(S) nwell_conn(B)

* +++++++++++++++++++++++++++++++++++++++++++++++++++++++++ *
* Sub cell: pmos1v_CDNS_777083821470                        *
* +++++++++++++++++++++++++++++++++++++++++++++++++++++++++ *
.subckt pmos1v_CDNS_777083821470 1 2 3
** N=4 EP=3 FDC=1
M0 1 2 3 1 g45p1svt L=4.5e-08 W=1.6e-07 AD=2.56e-14 AS=9.6e-15 PD=6.4e-07 PS=4.4e-07 fw=1.6e-07 sa=2.45e-07 sb=4.5e-07 sca=11.1246 scb=0.0104476 scc=0.000358271 $X=0 $Y=0 $dt=1
.ends pmos1v_CDNS_777083821470

* +++++++++++++++++++++++++++++++++++++++++++++++++++++++++ *
* Sub cell: pmos1v_CDNS_777083821471                        *
* +++++++++++++++++++++++++++++++++++++++++++++++++++++++++ *
.subckt pmos1v_CDNS_777083821471 1 2 3
** N=4 EP=3 FDC=1
M0 2 1 3 3 g45p1svt L=4.5e-08 W=1.6e-07 AD=9.6e-15 AS=2.56e-14 PD=4.4e-07 PS=6.4e-07 fw=1.6e-07 sa=4.5e-07 sb=2.45e-07 sca=11.8516 scb=0.0108532 scc=0.000358591 $X=0 $Y=0 $dt=1
.ends pmos1v_CDNS_777083821471

* +++++++++++++++++++++++++++++++++++++++++++++++++++++++++ *
* Sub cell: pmos1v_CDNS_777083821472                        *
* +++++++++++++++++++++++++++++++++++++++++++++++++++++++++ *
.subckt pmos1v_CDNS_777083821472 1 2 3
** N=4 EP=3 FDC=1
M0 1 2 3 3 g45p1svt L=4.5e-08 W=1.6e-07 AD=2.24e-14 AS=2.56e-14 PD=6e-07 PS=6.4e-07 fw=1.6e-07 sa=1.48e-06 sb=1.4e-07 sca=10.9431 scb=0.0104049 scc=0.000358265 $X=0 $Y=0 $dt=1
.ends pmos1v_CDNS_777083821472

* +++++++++++++++++++++++++++++++++++++++++++++++++++++++++ *
* Sub cell: nmos1v_CDNS_777083821473                        *
* +++++++++++++++++++++++++++++++++++++++++++++++++++++++++ *
.subckt nmos1v_CDNS_777083821473 1 2 3
** N=3 EP=3 FDC=1
M0 3 2 1 1 g45n1svt L=4.5e-08 W=1.2e-07 AD=7.2e-15 AS=1.68e-14 PD=3.6e-07 PS=5.2e-07 fw=1.2e-07 sa=1.4e-07 sb=1.48e-06 sca=5.43278 scb=0.00141223 scc=3.10179e-06 $X=0 $Y=0 $dt=0
.ends nmos1v_CDNS_777083821473

* +++++++++++++++++++++++++++++++++++++++++++++++++++++++++ *
* Sub cell: pmos1v_CDNS_777083821474                        *
* +++++++++++++++++++++++++++++++++++++++++++++++++++++++++ *
.subckt pmos1v_CDNS_777083821474 1 2 3 5
** N=5 EP=4 FDC=1
M0 2 1 3 5 g45p1svt L=4.5e-08 W=1.6e-07 AD=2.56e-14 AS=9.6e-15 PD=6.4e-07 PS=4.4e-07 fw=1.6e-07 sa=1.17e-06 sb=4.5e-07 sca=13.1517 scb=0.0124073 scc=0.000365785 $X=0 $Y=0 $dt=1
.ends pmos1v_CDNS_777083821474

* +++++++++++++++++++++++++++++++++++++++++++++++++++++++++ *
* Sub cell: pmos1v_CDNS_777083821475                        *
* +++++++++++++++++++++++++++++++++++++++++++++++++++++++++ *
.subckt pmos1v_CDNS_777083821475 1 2 3 5
** N=5 EP=4 FDC=1
M0 1 2 3 5 g45p1svt L=4.5e-08 W=1.6e-07 AD=2.56e-14 AS=9.6e-15 PD=6.4e-07 PS=4.4e-07 fw=1.6e-07 sa=2.45e-07 sb=1.375e-06 sca=17.8416 scb=0.0204203 scc=0.000645716 $X=0 $Y=0 $dt=1
.ends pmos1v_CDNS_777083821475

* +++++++++++++++++++++++++++++++++++++++++++++++++++++++++ *
* Sub cell: pmos1v_CDNS_777083821476                        *
* +++++++++++++++++++++++++++++++++++++++++++++++++++++++++ *
.subckt pmos1v_CDNS_777083821476 1 2 3
** N=4 EP=3 FDC=1
M0 3 2 1 1 g45p1svt L=4.5e-08 W=1.6e-07 AD=9.6e-15 AS=2.24e-14 PD=4.4e-07 PS=6e-07 fw=1.6e-07 sa=1.4e-07 sb=1.48e-06 sca=25.7964 scb=0.0306175 scc=0.00200972 $X=0 $Y=0 $dt=1
.ends pmos1v_CDNS_777083821476

* +++++++++++++++++++++++++++++++++++++++++++++++++++++++++ *
* Sub cell: pmos1v_CDNS_777083821477                        *
* +++++++++++++++++++++++++++++++++++++++++++++++++++++++++ *
.subckt pmos1v_CDNS_777083821477 1 2 3
** N=4 EP=3 FDC=1
M0 1 2 3 3 g45p1svt L=4.5e-08 W=1.6e-07 AD=2.56e-14 AS=2.56e-14 PD=6.4e-07 PS=6.4e-07 fw=1.6e-07 sa=7.6e-07 sb=8.6e-07 sca=11.3006 scb=0.0105103 scc=0.000358287 $X=0 $Y=0 $dt=1
.ends pmos1v_CDNS_777083821477

* +++++++++++++++++++++++++++++++++++++++++++++++++++++++++ *
* Sub cell: pmos1v_CDNS_777083821478                        *
* +++++++++++++++++++++++++++++++++++++++++++++++++++++++++ *
.subckt pmos1v_CDNS_777083821478 1 2 3 5
** N=5 EP=4 FDC=1
M0 3 2 1 5 g45p1svt L=4.5e-08 W=1.6e-07 AD=2.56e-14 AS=2.56e-14 PD=6.4e-07 PS=6.4e-07 fw=1.6e-07 sa=6.55e-07 sb=9.65e-07 sca=10.9431 scb=0.0104049 scc=0.000358265 $X=0 $Y=0 $dt=1
.ends pmos1v_CDNS_777083821478

* +++++++++++++++++++++++++++++++++++++++++++++++++++++++++ *
* Sub cell: nmos1v_CDNS_777083821479                        *
* +++++++++++++++++++++++++++++++++++++++++++++++++++++++++ *
.subckt nmos1v_CDNS_777083821479 1 2 3 4
*.DEVICECLIMB
** N=4 EP=4 FDC=1
M0 1 2 3 4 g45n1svt L=4.5e-08 W=1.2e-07 AD=1.92e-14 AS=7.2e-15 PD=5.6e-07 PS=3.6e-07 fw=1.2e-07 sa=2.45e-07 sb=1.375e-06 sca=5.43278 scb=0.00141223 scc=3.10179e-06 $X=0 $Y=0 $dt=0
.ends nmos1v_CDNS_777083821479

* +++++++++++++++++++++++++++++++++++++++++++++++++++++++++ *
* Sub cell: nmos1v_CDNS_7770838214714                       *
* +++++++++++++++++++++++++++++++++++++++++++++++++++++++++ *
.subckt nmos1v_CDNS_7770838214714 1 2 3
** N=3 EP=3 FDC=1
M0 1 2 3 3 g45n1svt L=4.5e-08 W=1.2e-07 AD=1.92e-14 AS=1.92e-14 PD=5.6e-07 PS=5.6e-07 fw=1.2e-07 sa=7.6e-07 sb=8.6e-07 sca=5.43278 scb=0.00141223 scc=3.10179e-06 $X=0 $Y=0 $dt=0
.ends nmos1v_CDNS_7770838214714

* +++++++++++++++++++++++++++++++++++++++++++++++++++++++++ *
* Sub cell: nmos1v_CDNS_7770838214715                       *
* +++++++++++++++++++++++++++++++++++++++++++++++++++++++++ *
.subckt nmos1v_CDNS_7770838214715 1 2 3 4
*.DEVICECLIMB
** N=4 EP=4 FDC=1
M0 3 2 1 4 g45n1svt L=4.5e-08 W=1.2e-07 AD=1.92e-14 AS=1.92e-14 PD=5.6e-07 PS=5.6e-07 fw=1.2e-07 sa=6.55e-07 sb=9.65e-07 sca=5.43278 scb=0.00141223 scc=3.10179e-06 $X=0 $Y=0 $dt=0
.ends nmos1v_CDNS_7770838214715

* +++++++++++++++++++++++++++++++++++++++++++++++++++++++++ *
* Sub cell: pmos1v_CDNS_7770838214716                       *
* +++++++++++++++++++++++++++++++++++++++++++++++++++++++++ *
.subckt pmos1v_CDNS_7770838214716 1 2 3 5
** N=5 EP=4 FDC=1
M0 2 1 3 5 g45p1svt L=4.5e-08 W=1.6e-07 AD=2.56e-14 AS=9.6e-15 PD=6.4e-07 PS=4.4e-07 fw=1.6e-07 sa=4.5e-07 sb=1.17e-06 sca=10.9431 scb=0.0104049 scc=0.000358265 $X=0 $Y=0 $dt=1
.ends pmos1v_CDNS_7770838214716

* +++++++++++++++++++++++++++++++++++++++++++++++++++++++++ *
* Sub cell: nmos1v_CDNS_7770838214717                       *
* +++++++++++++++++++++++++++++++++++++++++++++++++++++++++ *
.subckt nmos1v_CDNS_7770838214717 1 2 3
** N=3 EP=3 FDC=1
M0 1 2 3 3 g45n1svt L=4.5e-08 W=1.2e-07 AD=1.68e-14 AS=1.92e-14 PD=5.2e-07 PS=5.6e-07 fw=1.2e-07 sa=1.48e-06 sb=1.4e-07 sca=5.43278 scb=0.00141223 scc=3.10179e-06 $X=0 $Y=0 $dt=0
.ends nmos1v_CDNS_7770838214717

* +++++++++++++++++++++++++++++++++++++++++++++++++++++++++ *
* Sub cell: pmos1v_CDNS_7770838214718                       *
* +++++++++++++++++++++++++++++++++++++++++++++++++++++++++ *
.subckt pmos1v_CDNS_7770838214718 1 2 3 5
** N=5 EP=4 FDC=1
M0 1 2 3 5 g45p1svt L=4.5e-08 W=1.6e-07 AD=2.24e-14 AS=9.6e-15 PD=6e-07 PS=4.4e-07 fw=1.6e-07 sa=5.55e-07 sb=1.4e-07 sca=10.9431 scb=0.0104049 scc=0.000358265 $X=0 $Y=0 $dt=1
.ends pmos1v_CDNS_7770838214718

* +++++++++++++++++++++++++++++++++++++++++++++++++++++++++ *
* Sub cell: nmos1v_CDNS_7770838214719                       *
* +++++++++++++++++++++++++++++++++++++++++++++++++++++++++ *
.subckt nmos1v_CDNS_7770838214719 1 2 3 4
** N=4 EP=4 FDC=1
M0 1 2 3 4 g45n1svt L=4.5e-08 W=1.2e-07 AD=1.68e-14 AS=7.2e-15 PD=5.2e-07 PS=3.6e-07 fw=1.2e-07 sa=5.55e-07 sb=1.4e-07 sca=5.43278 scb=0.00141223 scc=3.10179e-06 $X=0 $Y=0 $dt=0
.ends nmos1v_CDNS_7770838214719

* +++++++++++++++++++++++++++++++++++++++++++++++++++++++++ *
* Sub cell: pmos1v_CDNS_7770838214720                       *
* +++++++++++++++++++++++++++++++++++++++++++++++++++++++++ *
.subckt pmos1v_CDNS_7770838214720 1 2 3 5
** N=5 EP=4 FDC=1
M0 1 2 3 5 g45p1svt L=4.5e-08 W=1.6e-07 AD=2.24e-14 AS=9.6e-15 PD=6e-07 PS=4.4e-07 fw=1.6e-07 sa=5.55e-07 sb=1.4e-07 sca=12.5291 scb=0.0115558 scc=0.000360552 $X=0 $Y=0 $dt=1
.ends pmos1v_CDNS_7770838214720

* +++++++++++++++++++++++++++++++++++++++++++++++++++++++++ *
* Sub cell: RFReg                                           *
* +++++++++++++++++++++++++++++++++++++++++++++++++++++++++ *
.subckt RFReg D clk clk_b gnd! rdata0 rdata1 ren0 ren0_b ren1 ren1_b
+ vdd!
** N=25 EP=11 FDC=26
X19 vdd! 4 13 pmos1v_CDNS_777083821470 $T=4120 3040 0 0 $X=3920 $Y=2840
X20 4 15 vdd! pmos1v_CDNS_777083821471 $T=4530 3040 0 0 $X=4290 $Y=2840
X21 4 5 vdd! pmos1v_CDNS_777083821472 $T=3100 3040 0 0 $X=2860 $Y=2840
X22 gnd! D 16 nmos1v_CDNS_777083821473 $T=420 1120 0 0 $X=0 $Y=920
X23 clk_b 3 17 vdd! pmos1v_CDNS_777083821474 $T=1130 3040 1 180 $X=800 $Y=2840
X24 3 clk 18 vdd! pmos1v_CDNS_777083821475 $T=630 3040 0 0 $X=430 $Y=2840
X25 vdd! D 18 pmos1v_CDNS_777083821476 $T=420 3040 0 0 $X=0 $Y=2840
X26 2 3 vdd! pmos1v_CDNS_777083821477 $T=1660 3040 0 0 $X=1420 $Y=2840
X27 5 clk_b 2 vdd! pmos1v_CDNS_777083821478 $T=2160 3040 1 180 $X=1830 $Y=2840
X28 3 clk_b 16 gnd! nmos1v_CDNS_777083821479 $T=630 1120 0 0 $X=430 $Y=920
X34 2 3 gnd! nmos1v_CDNS_7770838214714 $T=1660 1120 0 0 $X=1420 $Y=920
X35 5 clk 2 gnd! nmos1v_CDNS_7770838214715 $T=2160 1120 1 180 $X=1830 $Y=920
X36 clk 5 19 vdd! pmos1v_CDNS_7770838214716 $T=2570 3040 1 180 $X=2240 $Y=2840
X37 4 5 gnd! nmos1v_CDNS_7770838214717 $T=3100 1120 0 0 $X=2860 $Y=920
X38 rdata0 ren0_b 13 vdd! pmos1v_CDNS_7770838214718 $T=4000 3040 1 180 $X=3490 $Y=2840
X39 rdata0 ren0 22 gnd! nmos1v_CDNS_7770838214719 $T=4000 1120 1 180 $X=3490 $Y=920
X40 rdata1 ren1 25 gnd! nmos1v_CDNS_7770838214719 $T=4740 1120 0 0 $X=4540 $Y=920
X41 rdata1 ren1_b 15 vdd! pmos1v_CDNS_7770838214720 $T=4740 3040 0 0 $X=4540 $Y=2840
M0 20 clk 3 gnd! g45n1svt L=4.5e-08 W=1.2e-07 AD=7.2e-15 AS=1.92e-14 PD=3.6e-07 PS=5.6e-07 fw=1.2e-07 sa=4.5e-07 sb=1.17e-06 sca=5.43278 scb=0.00141223 scc=3.10179e-06 $X=1040 $Y=1120 $dt=0
M1 gnd! 2 20 gnd! g45n1svt L=4.5e-08 W=1.2e-07 AD=1.92e-14 AS=7.2e-15 PD=5.6e-07 PS=3.6e-07 fw=1.2e-07 sa=5.55e-07 sb=1.065e-06 sca=5.43278 scb=0.00141223 scc=3.10179e-06 $X=1250 $Y=1120 $dt=0
M2 21 clk_b 5 gnd! g45n1svt L=4.5e-08 W=1.2e-07 AD=7.2e-15 AS=1.92e-14 PD=3.6e-07 PS=5.6e-07 fw=1.2e-07 sa=1.17e-06 sb=4.5e-07 sca=5.43278 scb=0.00141223 scc=3.10179e-06 $X=2480 $Y=1120 $dt=0
M3 gnd! 4 21 gnd! g45n1svt L=4.5e-08 W=1.2e-07 AD=1.92e-14 AS=7.2e-15 PD=5.6e-07 PS=3.6e-07 fw=1.2e-07 sa=1.275e-06 sb=3.45e-07 sca=5.43278 scb=0.00141223 scc=3.10179e-06 $X=2690 $Y=1120 $dt=0
M4 gnd! 4 22 gnd! g45n1svt L=4.5e-08 W=1.2e-07 AD=1.92e-14 AS=7.2e-15 PD=5.6e-07 PS=3.6e-07 fw=1.2e-07 sa=2.45e-07 sb=4.5e-07 sca=5.43278 scb=0.00141223 scc=3.10179e-06 $X=4120 $Y=1120 $dt=0
M5 25 4 gnd! gnd! g45n1svt L=4.5e-08 W=1.2e-07 AD=7.2e-15 AS=1.92e-14 PD=3.6e-07 PS=5.6e-07 fw=1.2e-07 sa=4.5e-07 sb=2.45e-07 sca=5.43278 scb=0.00141223 scc=3.10179e-06 $X=4530 $Y=1120 $dt=0
M6 vdd! 2 17 vdd! g45p1svt L=4.5e-08 W=1.6e-07 AD=2.56e-14 AS=9.6e-15 PD=6.4e-07 PS=4.4e-07 fw=1.6e-07 sa=5.55e-07 sb=1.065e-06 sca=12.2331 scb=0.011215 scc=0.000359358 $X=1250 $Y=3040 $dt=1
M7 vdd! 4 19 vdd! g45p1svt L=4.5e-08 W=1.6e-07 AD=2.56e-14 AS=9.6e-15 PD=6.4e-07 PS=4.4e-07 fw=1.6e-07 sa=1.275e-06 sb=3.45e-07 sca=10.9431 scb=0.0104049 scc=0.000358265 $X=2690 $Y=3040 $dt=1
.ends RFReg
