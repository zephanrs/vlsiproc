* +++++++++++++++++++++++++++++++++++++++++++++++++++++++++ *
* CDL Netlist:                                              *
*                                                           *
* Cell Name  : clk_ena                                      *
* Netlisted  : Fri Apr 24 21:27:25 2026                     *
* Pegasus Version: 23.23-s012 Wed May 29 16:54:16 PDT 2024  *
* +++++++++++++++++++++++++++++++++++++++++++++++++++++++++ *
*.LDD
*.DEVTMPLT 0 MN(g45n1svt) _nmos1v ndiff_conn(D) poly_conn(G) ndiff_conn(S) psubstrate(B)
*.DEVTMPLT 1 MP(g45p1svt) _pmos1v pdiff_conn(D) poly_conn(G) pdiff_conn(S) nwell_conn(B)

* +++++++++++++++++++++++++++++++++++++++++++++++++++++++++ *
* Sub cell: nmos1v_CDNS_777080441100                        *
* +++++++++++++++++++++++++++++++++++++++++++++++++++++++++ *
.subckt nmos1v_CDNS_777080441100 1 2 3
** N=3 EP=3 FDC=1
M0 2 3 1 2 g45n1svt L=4.5e-08 W=1.2e-07 AD=1.92e-14 AS=1.68e-14 PD=5.6e-07 PS=5.2e-07 fw=1.2e-07 sa=1.4e-07 sb=3.45e-07 sca=5.81154 scb=0.00192795 scc=6.43757e-06 $X=0 $Y=0 $dt=0
.ends nmos1v_CDNS_777080441100

* +++++++++++++++++++++++++++++++++++++++++++++++++++++++++ *
* Sub cell: pmos1v_CDNS_777080441102                        *
* +++++++++++++++++++++++++++++++++++++++++++++++++++++++++ *
.subckt pmos1v_CDNS_777080441102 1 2 3
*.DEVICECLIMB
** N=4 EP=3 FDC=1
M0 3 2 1 1 g45p1svt L=4.5e-08 W=1.6e-07 AD=9.6e-15 AS=2.24e-14 PD=4.4e-07 PS=6e-07 fw=1.6e-07 sa=1.4e-07 sb=7.6e-07 sca=23.6766 scb=0.0269922 scc=0.0017794 $X=0 $Y=0 $dt=1
.ends pmos1v_CDNS_777080441102

* +++++++++++++++++++++++++++++++++++++++++++++++++++++++++ *
* Sub cell: nmos1v_CDNS_777080441103                        *
* +++++++++++++++++++++++++++++++++++++++++++++++++++++++++ *
.subckt nmos1v_CDNS_777080441103 1 2 3
** N=3 EP=3 FDC=1
M0 3 2 1 3 g45n1svt L=4.5e-08 W=1.2e-07 AD=1.92e-14 AS=1.68e-14 PD=5.6e-07 PS=5.2e-07 fw=1.2e-07 sa=1.4e-07 sb=3.45e-07 sca=5.81154 scb=0.00192795 scc=6.43757e-06 $X=0 $Y=0 $dt=0
.ends nmos1v_CDNS_777080441103

* +++++++++++++++++++++++++++++++++++++++++++++++++++++++++ *
* Sub cell: pmos1v_CDNS_777080441104                        *
* +++++++++++++++++++++++++++++++++++++++++++++++++++++++++ *
.subckt pmos1v_CDNS_777080441104 1 2 3
** N=4 EP=3 FDC=1
M0 1 2 3 3 g45p1svt L=4.5e-08 W=1.6e-07 AD=2.24e-14 AS=2.56e-14 PD=6e-07 PS=6.4e-07 fw=1.6e-07 sa=7.6e-07 sb=1.4e-07 sca=9.18079 scb=0.00688492 scc=0.000127967 $X=0 $Y=0 $dt=1
.ends pmos1v_CDNS_777080441104

* +++++++++++++++++++++++++++++++++++++++++++++++++++++++++ *
* Sub cell: nmos1v_CDNS_777080441106                        *
* +++++++++++++++++++++++++++++++++++++++++++++++++++++++++ *
.subckt nmos1v_CDNS_777080441106 1 2 3
** N=3 EP=3 FDC=1
M0 3 2 1 1 g45n1svt L=4.5e-08 W=1.2e-07 AD=7.2e-15 AS=1.68e-14 PD=3.6e-07 PS=5.2e-07 fw=1.2e-07 sa=1.4e-07 sb=7.6e-07 sca=5.81154 scb=0.00192795 scc=6.43757e-06 $X=0 $Y=0 $dt=0
.ends nmos1v_CDNS_777080441106

* +++++++++++++++++++++++++++++++++++++++++++++++++++++++++ *
* Sub cell: nmos1v_CDNS_777080441107                        *
* +++++++++++++++++++++++++++++++++++++++++++++++++++++++++ *
.subckt nmos1v_CDNS_777080441107 1 2 3
*.DEVICECLIMB
** N=3 EP=3 FDC=1
M0 3 2 1 1 g45n1svt L=4.5e-08 W=1.2e-07 AD=7.2e-15 AS=1.92e-14 PD=3.6e-07 PS=5.6e-07 fw=1.2e-07 sa=3.45e-07 sb=5.55e-07 sca=5.81154 scb=0.00192795 scc=6.43757e-06 $X=0 $Y=0 $dt=0
.ends nmos1v_CDNS_777080441107

* +++++++++++++++++++++++++++++++++++++++++++++++++++++++++ *
* Sub cell: nmos1v_CDNS_777080441108                        *
* +++++++++++++++++++++++++++++++++++++++++++++++++++++++++ *
.subckt nmos1v_CDNS_777080441108 1 2 3 4
** N=4 EP=4 FDC=1
M0 1 2 3 4 g45n1svt L=4.5e-08 W=2.4e-07 AD=3.36e-14 AS=1.44e-14 PD=7.6e-07 PS=6e-07 fw=2.4e-07 sa=2.45e-07 sb=1.4e-07 sca=5.25069 scb=0.00133893 scc=3.57481e-06 $X=0 $Y=0 $dt=0
.ends nmos1v_CDNS_777080441108

* +++++++++++++++++++++++++++++++++++++++++++++++++++++++++ *
* Sub cell: nmos1v_CDNS_7770804411010                       *
* +++++++++++++++++++++++++++++++++++++++++++++++++++++++++ *
.subckt nmos1v_CDNS_7770804411010 1 2 3
** N=3 EP=3 FDC=1
M0 3 2 1 1 g45n1svt L=4.5e-08 W=2.4e-07 AD=1.44e-14 AS=3.36e-14 PD=6e-07 PS=7.6e-07 fw=2.4e-07 sa=1.4e-07 sb=2.45e-07 sca=5.25069 scb=0.00133893 scc=3.57481e-06 $X=0 $Y=0 $dt=0
.ends nmos1v_CDNS_7770804411010

* +++++++++++++++++++++++++++++++++++++++++++++++++++++++++ *
* Sub cell: nmos1v_CDNS_7770804411012                       *
* +++++++++++++++++++++++++++++++++++++++++++++++++++++++++ *
.subckt nmos1v_CDNS_7770804411012 1 2 3
** N=3 EP=3 FDC=1
M0 1 2 3 3 g45n1svt L=4.5e-08 W=1.2e-07 AD=1.68e-14 AS=1.92e-14 PD=5.2e-07 PS=5.6e-07 fw=1.2e-07 sa=7.6e-07 sb=1.4e-07 sca=5.81154 scb=0.00192795 scc=6.43757e-06 $X=0 $Y=0 $dt=0
.ends nmos1v_CDNS_7770804411012

* +++++++++++++++++++++++++++++++++++++++++++++++++++++++++ *
* Sub cell: nmos1v_CDNS_7770804411013                       *
* +++++++++++++++++++++++++++++++++++++++++++++++++++++++++ *
.subckt nmos1v_CDNS_7770804411013 1 2 3 4
*.DEVICECLIMB
** N=4 EP=4 FDC=1
M0 1 2 3 4 g45n1svt L=4.5e-08 W=1.2e-07 AD=1.92e-14 AS=7.2e-15 PD=5.6e-07 PS=3.6e-07 fw=1.2e-07 sa=2.45e-07 sb=6.55e-07 sca=5.81154 scb=0.00192795 scc=6.43757e-06 $X=0 $Y=0 $dt=0
.ends nmos1v_CDNS_7770804411013

* +++++++++++++++++++++++++++++++++++++++++++++++++++++++++ *
* Sub cell: pmos1v_CDNS_7770804411014                       *
* +++++++++++++++++++++++++++++++++++++++++++++++++++++++++ *
.subckt pmos1v_CDNS_7770804411014 1 2 3
** N=4 EP=3 FDC=1
M0 1 2 3 1 g45p1svt L=4.5e-08 W=1.6e-07 AD=2.56e-14 AS=9.6e-15 PD=6.4e-07 PS=4.4e-07 fw=1.6e-07 sa=5.55e-07 sb=3.45e-07 sca=10.1132 scb=0.00758966 scc=0.000129037 $X=0 $Y=0 $dt=1
.ends pmos1v_CDNS_7770804411014

* +++++++++++++++++++++++++++++++++++++++++++++++++++++++++ *
* Sub cell: pmos1v_CDNS_7770804411015                       *
* +++++++++++++++++++++++++++++++++++++++++++++++++++++++++ *
.subckt pmos1v_CDNS_7770804411015 1 2 3 5
*.DEVICECLIMB
** N=5 EP=4 FDC=1
M0 3 2 1 5 g45p1svt L=4.5e-08 W=1.6e-07 AD=9.6e-15 AS=2.56e-14 PD=4.4e-07 PS=6.4e-07 fw=1.6e-07 sa=4.5e-07 sb=4.5e-07 sca=11.0319 scb=0.00878198 scc=0.000135464 $X=0 $Y=0 $dt=1
.ends pmos1v_CDNS_7770804411015

* +++++++++++++++++++++++++++++++++++++++++++++++++++++++++ *
* Sub cell: clk_ena                                         *
* +++++++++++++++++++++++++++++++++++++++++++++++++++++++++ *
.subckt clk_ena clk ena ena_clk_b gnd! vdd!
** N=14 EP=5 FDC=18
X12 5 gnd! clk nmos1v_CDNS_777080441100 $T=2970 1200 1 180 $X=2520 $Y=1000
X13 vdd! ena 8 pmos1v_CDNS_777080441102 $T=420 3160 0 0 $X=0 $Y=2960
X14 9 5 gnd! nmos1v_CDNS_777080441103 $T=2470 1200 0 0 $X=2050 $Y=1000
X15 2 4 vdd! pmos1v_CDNS_777080441104 $T=1660 3160 0 0 $X=1420 $Y=2960
X18 gnd! ena 11 nmos1v_CDNS_777080441106 $T=420 1200 0 0 $X=0 $Y=1000
X19 gnd! 2 12 nmos1v_CDNS_777080441107 $T=1340 1200 1 180 $X=1050 $Y=1000
X20 ena_clk_b 9 13 gnd! nmos1v_CDNS_777080441108 $T=4080 960 0 0 $X=3880 $Y=760
X21 gnd! 2 13 nmos1v_CDNS_7770804411010 $T=3870 960 0 0 $X=3450 $Y=760
X24 2 4 gnd! nmos1v_CDNS_7770804411012 $T=1660 1200 0 0 $X=1420 $Y=1000
X25 4 5 11 gnd! nmos1v_CDNS_7770804411013 $T=630 1200 0 0 $X=430 $Y=1000
X26 vdd! 2 14 pmos1v_CDNS_7770804411014 $T=1250 3160 0 0 $X=1050 $Y=2960
X27 4 5 14 vdd! pmos1v_CDNS_7770804411015 $T=1040 3160 0 0 $X=680 $Y=2960
M0 12 9 4 gnd! g45n1svt L=4.5e-08 W=1.2e-07 AD=7.2e-15 AS=1.92e-14 PD=3.6e-07 PS=5.6e-07 fw=1.2e-07 sa=4.5e-07 sb=4.5e-07 sca=5.81154 scb=0.00192795 scc=6.43757e-06 $X=1040 $Y=1200 $dt=0
M1 4 9 8 vdd! g45p1svt L=4.5e-08 W=1.6e-07 AD=2.56e-14 AS=9.6e-15 PD=6.4e-07 PS=4.4e-07 fw=1.6e-07 sa=2.45e-07 sb=6.55e-07 sca=15.7218 scb=0.016795 scc=0.000415395 $X=630 $Y=3160 $dt=1
M2 vdd! 5 9 vdd! g45p1svt L=4.5e-08 W=1.6e-07 AD=2.56e-14 AS=2.24e-14 PD=6.4e-07 PS=6e-07 fw=1.6e-07 sa=1.4e-07 sb=3.45e-07 sca=8.82324 scb=0.00677956 scc=0.000127945 $X=2470 $Y=3160 $dt=1
M3 5 clk vdd! vdd! g45p1svt L=4.5e-08 W=1.6e-07 AD=2.24e-14 AS=2.56e-14 PD=6e-07 PS=6.4e-07 fw=1.6e-07 sa=3.45e-07 sb=1.4e-07 sca=8.82324 scb=0.00677956 scc=0.000127945 $X=2880 $Y=3160 $dt=1
M4 ena_clk_b 2 vdd! vdd! g45p1svt L=4.5e-08 W=1.6e-07 AD=2.56e-14 AS=2.24e-14 PD=6.4e-07 PS=6e-07 fw=1.6e-07 sa=1.4e-07 sb=3.45e-07 sca=10.2179 scb=0.00770462 scc=0.000129387 $X=3690 $Y=3160 $dt=1
M5 vdd! 9 ena_clk_b vdd! g45p1svt L=4.5e-08 W=1.6e-07 AD=2.24e-14 AS=2.56e-14 PD=6e-07 PS=6.4e-07 fw=1.6e-07 sa=3.45e-07 sb=1.4e-07 sca=12.8726 scb=0.0118632 scc=0.000187533 $X=4100 $Y=3160 $dt=1
.ends clk_ena
