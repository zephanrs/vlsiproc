* +++++++++++++++++++++++++++++++++++++++++++++++++++++++++ *
* CDL Netlist:                                              *
*                                                           *
* Cell Name  : RFzero                                       *
* Netlisted  : Fri Apr 24 22:38:49 2026                     *
* Pegasus Version: 23.23-s012 Wed May 29 16:54:16 PDT 2024  *
* +++++++++++++++++++++++++++++++++++++++++++++++++++++++++ *
*.LDD
*.DEVTMPLT 0 MN(g45n1svt) _nmos1v ndiff_conn(D) poly_conn(G) ndiff_conn(S) psubstrate(B)

* +++++++++++++++++++++++++++++++++++++++++++++++++++++++++ *
* Sub cell: nmos1v_CDNS_777084724640                        *
* +++++++++++++++++++++++++++++++++++++++++++++++++++++++++ *
.subckt nmos1v_CDNS_777084724640 1 2 3
** N=3 EP=3 FDC=1
M0 1 2 3 3 g45n1svt L=4.5e-08 W=1.2e-07 AD=1.68e-14 AS=1.92e-14 PD=5.2e-07 PS=5.6e-07 fw=1.2e-07 sa=3.45e-07 sb=1.4e-07 sca=6.27895 scb=0.00263413 scc=1.32963e-05 $X=0 $Y=0 $dt=0
.ends nmos1v_CDNS_777084724640

* +++++++++++++++++++++++++++++++++++++++++++++++++++++++++ *
* Sub cell: nmos1v_CDNS_777084724641                        *
* +++++++++++++++++++++++++++++++++++++++++++++++++++++++++ *
.subckt nmos1v_CDNS_777084724641 1 2 3
** N=3 EP=3 FDC=1
M0 1 3 2 2 g45n1svt L=4.5e-08 W=1.2e-07 AD=1.68e-14 AS=1.92e-14 PD=5.2e-07 PS=5.6e-07 fw=1.2e-07 sa=3.45e-07 sb=1.4e-07 sca=6.27895 scb=0.00263413 scc=1.32963e-05 $X=0 $Y=0 $dt=0
.ends nmos1v_CDNS_777084724641

* +++++++++++++++++++++++++++++++++++++++++++++++++++++++++ *
* Sub cell: RFzero                                          *
* +++++++++++++++++++++++++++++++++++++++++++++++++++++++++ *
.subckt RFzero gnd! rdata0 rdata1 ren0 ren1
** N=6 EP=5 FDC=2
X2 rdata1 ren1 gnd! nmos1v_CDNS_777084724640 $T=1160 1280 0 0 $X=920 $Y=1080
X3 rdata0 gnd! ren0 nmos1v_CDNS_777084724641 $T=840 1280 1 180 $X=330 $Y=1080
.ends RFzero
