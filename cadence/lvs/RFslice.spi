* +++++++++++++++++++++++++++++++++++++++++++++++++++++++++ *
* CDL Netlist:                                              *
*                                                           *
* Cell Name  : RFslice                                      *
* Netlisted  : Fri Apr 24 22:58:25 2026                     *
* Pegasus Version: 23.23-s012 Wed May 29 16:54:16 PDT 2024  *
* +++++++++++++++++++++++++++++++++++++++++++++++++++++++++ *
*.LDD
*.DEVTMPLT 0 MN(g45n1svt) _nmos1v ndiff_conn(D) poly_conn(G) ndiff_conn(S) psubstrate(B)
*.DEVTMPLT 1 MP(g45p1svt) _pmos1v pdiff_conn(D) poly_conn(G) pdiff_conn(S) nwell_conn(B)

* +++++++++++++++++++++++++++++++++++++++++++++++++++++++++ *
* Sub cell: nmos1v_CDNS_777085901160                        *
* +++++++++++++++++++++++++++++++++++++++++++++++++++++++++ *
.subckt nmos1v_CDNS_777085901160 1 2 3
** N=3 EP=3 FDC=1
M0 2 3 1 1 g45n1svt L=4.5e-08 W=1.2e-07 AD=1.68e-14 AS=1.68e-14 PD=5.2e-07 PS=5.2e-07 fw=1.2e-07 sa=1.4e-07 sb=1.4e-07 sca=4.13423 scb=0.000254067 scc=3.31832e-08 $X=0 $Y=0 $dt=0
.ends nmos1v_CDNS_777085901160

* +++++++++++++++++++++++++++++++++++++++++++++++++++++++++ *
* Sub cell: inv_x1                                          *
* +++++++++++++++++++++++++++++++++++++++++++++++++++++++++ *
.subckt inv_x1 in vdd! gnd! out
*.DEVICECLIMB
** N=4 EP=4 FDC=1
X3 gnd! out in nmos1v_CDNS_777085901160 $T=360 660 0 0 $X=-60 $Y=460
.ends inv_x1

* +++++++++++++++++++++++++++++++++++++++++++++++++++++++++ *
* Sub cell: nmos1v_CDNS_777085901163                        *
* +++++++++++++++++++++++++++++++++++++++++++++++++++++++++ *
.subckt nmos1v_CDNS_777085901163 1 2 3
** N=3 EP=3 FDC=1
M0 2 3 1 1 g45n1svt L=4.5e-08 W=1.2e-07 AD=1.68e-14 AS=1.92e-14 PD=5.2e-07 PS=5.6e-07 fw=1.2e-07 sa=3.45e-07 sb=1.4e-07 sca=6.27895 scb=0.00263413 scc=1.32963e-05 $X=0 $Y=0 $dt=0
.ends nmos1v_CDNS_777085901163

* +++++++++++++++++++++++++++++++++++++++++++++++++++++++++ *
* Sub cell: RFzero                                          *
* +++++++++++++++++++++++++++++++++++++++++++++++++++++++++ *
.subckt RFzero rdata0 rdata1 gnd! ren0 ren1
** N=6 EP=5 FDC=2
X5 gnd! rdata0 ren0 nmos1v_CDNS_777085901163 $T=840 1280 1 180 $X=330 $Y=1080
M0 rdata1 ren1 gnd! gnd! g45n1svt L=4.5e-08 W=1.2e-07 AD=1.68e-14 AS=1.92e-14 PD=5.2e-07 PS=5.6e-07 fw=1.2e-07 sa=3.45e-07 sb=1.4e-07 sca=6.27895 scb=0.00263413 scc=1.32963e-05 $X=1160 $Y=1280 $dt=0
.ends RFzero

* +++++++++++++++++++++++++++++++++++++++++++++++++++++++++ *
* Sub cell: nmos1v_CDNS_777085901165                        *
* +++++++++++++++++++++++++++++++++++++++++++++++++++++++++ *
.subckt nmos1v_CDNS_777085901165 1 2 3
** N=3 EP=3 FDC=1
M0 1 3 2 2 g45n1svt L=4.5e-08 W=4.8e-07 AD=6.72e-14 AS=6.72e-14 PD=1.24e-06 PS=1.24e-06 fw=4.8e-07 sa=1.4e-07 sb=1.4e-07 sca=4.2604 scb=0.000545366 scc=7.2595e-07 $X=0 $Y=0 $dt=0
.ends nmos1v_CDNS_777085901165

* +++++++++++++++++++++++++++++++++++++++++++++++++++++++++ *
* Sub cell: inv_x4                                          *
* +++++++++++++++++++++++++++++++++++++++++++++++++++++++++ *
.subckt inv_x4 out in vdd! gnd!
*.DEVICECLIMB
** N=4 EP=4 FDC=1
X4 out gnd! in nmos1v_CDNS_777085901165 $T=360 420 0 0 $X=-60 $Y=220
.ends inv_x4

* +++++++++++++++++++++++++++++++++++++++++++++++++++++++++ *
* Sub cell: pmos1v_CDNS_777085901166                        *
* +++++++++++++++++++++++++++++++++++++++++++++++++++++++++ *
.subckt pmos1v_CDNS_777085901166 1 2 3
** N=4 EP=3 FDC=1
M0 1 2 3 1 g45p1svt L=4.5e-08 W=1.6e-07 AD=2.56e-14 AS=9.6e-15 PD=6.4e-07 PS=4.4e-07 fw=1.6e-07 sa=2.45e-07 sb=4.5e-07 sca=10.9431 scb=0.0104049 scc=0.000358265 $X=0 $Y=0 $dt=1
.ends pmos1v_CDNS_777085901166

* +++++++++++++++++++++++++++++++++++++++++++++++++++++++++ *
* Sub cell: pmos1v_CDNS_777085901167                        *
* +++++++++++++++++++++++++++++++++++++++++++++++++++++++++ *
.subckt pmos1v_CDNS_777085901167 1 2 3
** N=4 EP=3 FDC=1
M0 2 1 3 3 g45p1svt L=4.5e-08 W=1.6e-07 AD=9.6e-15 AS=2.56e-14 PD=4.4e-07 PS=6.4e-07 fw=1.6e-07 sa=4.5e-07 sb=2.45e-07 sca=10.9431 scb=0.0104049 scc=0.000358265 $X=0 $Y=0 $dt=1
.ends pmos1v_CDNS_777085901167

* +++++++++++++++++++++++++++++++++++++++++++++++++++++++++ *
* Sub cell: pmos1v_CDNS_777085901168                        *
* +++++++++++++++++++++++++++++++++++++++++++++++++++++++++ *
.subckt pmos1v_CDNS_777085901168 1 2 3
** N=4 EP=3 FDC=1
M0 1 2 3 3 g45p1svt L=4.5e-08 W=1.6e-07 AD=2.24e-14 AS=2.56e-14 PD=6e-07 PS=6.4e-07 fw=1.6e-07 sa=1.48e-06 sb=1.4e-07 sca=10.9431 scb=0.0104049 scc=0.000358265 $X=0 $Y=0 $dt=1
.ends pmos1v_CDNS_777085901168

* +++++++++++++++++++++++++++++++++++++++++++++++++++++++++ *
* Sub cell: nmos1v_CDNS_777085901169                        *
* +++++++++++++++++++++++++++++++++++++++++++++++++++++++++ *
.subckt nmos1v_CDNS_777085901169 1 2 3
** N=3 EP=3 FDC=1
M0 3 2 1 1 g45n1svt L=4.5e-08 W=1.2e-07 AD=7.2e-15 AS=1.68e-14 PD=3.6e-07 PS=5.2e-07 fw=1.2e-07 sa=1.4e-07 sb=1.48e-06 sca=5.43278 scb=0.00141223 scc=3.10179e-06 $X=0 $Y=0 $dt=0
.ends nmos1v_CDNS_777085901169

* +++++++++++++++++++++++++++++++++++++++++++++++++++++++++ *
* Sub cell: pmos1v_CDNS_7770859011610                       *
* +++++++++++++++++++++++++++++++++++++++++++++++++++++++++ *
.subckt pmos1v_CDNS_7770859011610 1 2 3 5
** N=5 EP=4 FDC=1
M0 2 1 3 5 g45p1svt L=4.5e-08 W=1.6e-07 AD=2.56e-14 AS=9.6e-15 PD=6.4e-07 PS=4.4e-07 fw=1.6e-07 sa=1.17e-06 sb=4.5e-07 sca=10.9431 scb=0.0104049 scc=0.000358265 $X=0 $Y=0 $dt=1
.ends pmos1v_CDNS_7770859011610

* +++++++++++++++++++++++++++++++++++++++++++++++++++++++++ *
* Sub cell: pmos1v_CDNS_7770859011611                       *
* +++++++++++++++++++++++++++++++++++++++++++++++++++++++++ *
.subckt pmos1v_CDNS_7770859011611 1 2 3 5
** N=5 EP=4 FDC=1
M0 1 2 3 5 g45p1svt L=4.5e-08 W=1.6e-07 AD=2.56e-14 AS=9.6e-15 PD=6.4e-07 PS=4.4e-07 fw=1.6e-07 sa=2.45e-07 sb=1.375e-06 sca=10.9431 scb=0.0104049 scc=0.000358265 $X=0 $Y=0 $dt=1
.ends pmos1v_CDNS_7770859011611

* +++++++++++++++++++++++++++++++++++++++++++++++++++++++++ *
* Sub cell: pmos1v_CDNS_7770859011612                       *
* +++++++++++++++++++++++++++++++++++++++++++++++++++++++++ *
.subckt pmos1v_CDNS_7770859011612 1 2 3
** N=4 EP=3 FDC=1
M0 3 2 1 1 g45p1svt L=4.5e-08 W=1.6e-07 AD=9.6e-15 AS=2.24e-14 PD=4.4e-07 PS=6e-07 fw=1.6e-07 sa=1.4e-07 sb=1.48e-06 sca=10.9431 scb=0.0104049 scc=0.000358265 $X=0 $Y=0 $dt=1
.ends pmos1v_CDNS_7770859011612

* +++++++++++++++++++++++++++++++++++++++++++++++++++++++++ *
* Sub cell: pmos1v_CDNS_7770859011613                       *
* +++++++++++++++++++++++++++++++++++++++++++++++++++++++++ *
.subckt pmos1v_CDNS_7770859011613 1 2 3
** N=4 EP=3 FDC=1
M0 1 2 3 3 g45p1svt L=4.5e-08 W=1.6e-07 AD=2.56e-14 AS=2.56e-14 PD=6.4e-07 PS=6.4e-07 fw=1.6e-07 sa=7.6e-07 sb=8.6e-07 sca=10.9431 scb=0.0104049 scc=0.000358265 $X=0 $Y=0 $dt=1
.ends pmos1v_CDNS_7770859011613

* +++++++++++++++++++++++++++++++++++++++++++++++++++++++++ *
* Sub cell: pmos1v_CDNS_7770859011614                       *
* +++++++++++++++++++++++++++++++++++++++++++++++++++++++++ *
.subckt pmos1v_CDNS_7770859011614 1 2 3 5
** N=5 EP=4 FDC=1
M0 3 2 1 5 g45p1svt L=4.5e-08 W=1.6e-07 AD=2.56e-14 AS=2.56e-14 PD=6.4e-07 PS=6.4e-07 fw=1.6e-07 sa=6.55e-07 sb=9.65e-07 sca=10.9431 scb=0.0104049 scc=0.000358265 $X=0 $Y=0 $dt=1
.ends pmos1v_CDNS_7770859011614

* +++++++++++++++++++++++++++++++++++++++++++++++++++++++++ *
* Sub cell: nmos1v_CDNS_7770859011615                       *
* +++++++++++++++++++++++++++++++++++++++++++++++++++++++++ *
.subckt nmos1v_CDNS_7770859011615 1 2 3 4
** N=4 EP=4 FDC=1
M0 1 2 3 4 g45n1svt L=4.5e-08 W=1.2e-07 AD=1.92e-14 AS=7.2e-15 PD=5.6e-07 PS=3.6e-07 fw=1.2e-07 sa=2.45e-07 sb=1.375e-06 sca=5.43278 scb=0.00141223 scc=3.10179e-06 $X=0 $Y=0 $dt=0
.ends nmos1v_CDNS_7770859011615

* +++++++++++++++++++++++++++++++++++++++++++++++++++++++++ *
* Sub cell: nmos1v_CDNS_7770859011617                       *
* +++++++++++++++++++++++++++++++++++++++++++++++++++++++++ *
.subckt nmos1v_CDNS_7770859011617 1 2 3 4
** N=4 EP=4 FDC=1
M0 2 1 3 4 g45n1svt L=4.5e-08 W=1.2e-07 AD=1.92e-14 AS=7.2e-15 PD=5.6e-07 PS=3.6e-07 fw=1.2e-07 sa=1.17e-06 sb=4.5e-07 sca=5.43278 scb=0.00141223 scc=3.10179e-06 $X=0 $Y=0 $dt=0
.ends nmos1v_CDNS_7770859011617

* +++++++++++++++++++++++++++++++++++++++++++++++++++++++++ *
* Sub cell: nmos1v_CDNS_7770859011619                       *
* +++++++++++++++++++++++++++++++++++++++++++++++++++++++++ *
.subckt nmos1v_CDNS_7770859011619 1 2 3 4
** N=4 EP=4 FDC=1
M0 2 1 3 4 g45n1svt L=4.5e-08 W=1.2e-07 AD=1.92e-14 AS=7.2e-15 PD=5.6e-07 PS=3.6e-07 fw=1.2e-07 sa=4.5e-07 sb=1.17e-06 sca=5.43278 scb=0.00141223 scc=3.10179e-06 $X=0 $Y=0 $dt=0
.ends nmos1v_CDNS_7770859011619

* +++++++++++++++++++++++++++++++++++++++++++++++++++++++++ *
* Sub cell: nmos1v_CDNS_7770859011620                       *
* +++++++++++++++++++++++++++++++++++++++++++++++++++++++++ *
.subckt nmos1v_CDNS_7770859011620 1 2 3
** N=3 EP=3 FDC=1
M0 1 2 3 3 g45n1svt L=4.5e-08 W=1.2e-07 AD=1.92e-14 AS=1.92e-14 PD=5.6e-07 PS=5.6e-07 fw=1.2e-07 sa=7.6e-07 sb=8.6e-07 sca=5.43278 scb=0.00141223 scc=3.10179e-06 $X=0 $Y=0 $dt=0
.ends nmos1v_CDNS_7770859011620

* +++++++++++++++++++++++++++++++++++++++++++++++++++++++++ *
* Sub cell: nmos1v_CDNS_7770859011621                       *
* +++++++++++++++++++++++++++++++++++++++++++++++++++++++++ *
.subckt nmos1v_CDNS_7770859011621 1 2 3 4
** N=4 EP=4 FDC=1
M0 3 2 1 4 g45n1svt L=4.5e-08 W=1.2e-07 AD=1.92e-14 AS=1.92e-14 PD=5.6e-07 PS=5.6e-07 fw=1.2e-07 sa=6.55e-07 sb=9.65e-07 sca=5.43278 scb=0.00141223 scc=3.10179e-06 $X=0 $Y=0 $dt=0
.ends nmos1v_CDNS_7770859011621

* +++++++++++++++++++++++++++++++++++++++++++++++++++++++++ *
* Sub cell: pmos1v_CDNS_7770859011622                       *
* +++++++++++++++++++++++++++++++++++++++++++++++++++++++++ *
.subckt pmos1v_CDNS_7770859011622 1 2 3 5
** N=5 EP=4 FDC=1
M0 2 1 3 5 g45p1svt L=4.5e-08 W=1.6e-07 AD=2.56e-14 AS=9.6e-15 PD=6.4e-07 PS=4.4e-07 fw=1.6e-07 sa=4.5e-07 sb=1.17e-06 sca=10.9431 scb=0.0104049 scc=0.000358265 $X=0 $Y=0 $dt=1
.ends pmos1v_CDNS_7770859011622

* +++++++++++++++++++++++++++++++++++++++++++++++++++++++++ *
* Sub cell: pmos1v_CDNS_7770859011623                       *
* +++++++++++++++++++++++++++++++++++++++++++++++++++++++++ *
.subckt pmos1v_CDNS_7770859011623 1 2 3 5
** N=5 EP=4 FDC=1
M0 1 2 3 5 g45p1svt L=4.5e-08 W=1.6e-07 AD=2.24e-14 AS=9.6e-15 PD=6e-07 PS=4.4e-07 fw=1.6e-07 sa=5.55e-07 sb=1.4e-07 sca=10.9431 scb=0.0104049 scc=0.000358265 $X=0 $Y=0 $dt=1
.ends pmos1v_CDNS_7770859011623

* +++++++++++++++++++++++++++++++++++++++++++++++++++++++++ *
* Sub cell: nmos1v_CDNS_7770859011624                       *
* +++++++++++++++++++++++++++++++++++++++++++++++++++++++++ *
.subckt nmos1v_CDNS_7770859011624 1 2 3 4
** N=4 EP=4 FDC=1
M0 1 2 3 4 g45n1svt L=4.5e-08 W=1.2e-07 AD=1.68e-14 AS=7.2e-15 PD=5.2e-07 PS=3.6e-07 fw=1.2e-07 sa=5.55e-07 sb=1.4e-07 sca=5.43278 scb=0.00141223 scc=3.10179e-06 $X=0 $Y=0 $dt=0
.ends nmos1v_CDNS_7770859011624

* +++++++++++++++++++++++++++++++++++++++++++++++++++++++++ *
* Sub cell: pmos1v_CDNS_7770859011625                       *
* +++++++++++++++++++++++++++++++++++++++++++++++++++++++++ *
.subckt pmos1v_CDNS_7770859011625 1 2 3 5
** N=5 EP=4 FDC=1
M0 1 2 3 5 g45p1svt L=4.5e-08 W=1.6e-07 AD=2.24e-14 AS=9.6e-15 PD=6e-07 PS=4.4e-07 fw=1.6e-07 sa=5.55e-07 sb=1.4e-07 sca=10.9431 scb=0.0104049 scc=0.000358265 $X=0 $Y=0 $dt=1
.ends pmos1v_CDNS_7770859011625

* +++++++++++++++++++++++++++++++++++++++++++++++++++++++++ *
* Sub cell: nmos1v_CDNS_7770859011626                       *
* +++++++++++++++++++++++++++++++++++++++++++++++++++++++++ *
.subckt nmos1v_CDNS_7770859011626 1 2 3
** N=3 EP=3 FDC=1
M0 2 1 3 3 g45n1svt L=4.5e-08 W=1.2e-07 AD=7.2e-15 AS=1.92e-14 PD=3.6e-07 PS=5.6e-07 fw=1.2e-07 sa=4.5e-07 sb=2.45e-07 sca=5.43278 scb=0.00141223 scc=3.10179e-06 $X=0 $Y=0 $dt=0
.ends nmos1v_CDNS_7770859011626

* +++++++++++++++++++++++++++++++++++++++++++++++++++++++++ *
* Sub cell: RFReg                                           *
* +++++++++++++++++++++++++++++++++++++++++++++++++++++++++ *
.subckt RFReg D vdd! gnd! clk clk_b ren0_b ren0 rdata0 ren1 ren1_b
+ rdata1
** N=25 EP=11 FDC=26
X22 vdd! 12 16 pmos1v_CDNS_777085901166 $T=4120 3040 0 0 $X=3920 $Y=2840
X23 12 17 vdd! pmos1v_CDNS_777085901167 $T=4530 3040 0 0 $X=4290 $Y=2840
X24 12 13 vdd! pmos1v_CDNS_777085901168 $T=3100 3040 0 0 $X=2860 $Y=2840
X25 gnd! D 18 nmos1v_CDNS_777085901169 $T=420 1120 0 0 $X=0 $Y=920
X26 clk_b 15 19 vdd! pmos1v_CDNS_7770859011610 $T=1130 3040 1 180 $X=800 $Y=2840
X27 15 clk 20 vdd! pmos1v_CDNS_7770859011611 $T=630 3040 0 0 $X=430 $Y=2840
X28 vdd! D 20 pmos1v_CDNS_7770859011612 $T=420 3040 0 0 $X=0 $Y=2840
X29 14 15 vdd! pmos1v_CDNS_7770859011613 $T=1660 3040 0 0 $X=1420 $Y=2840
X30 13 clk_b 14 vdd! pmos1v_CDNS_7770859011614 $T=2160 3040 1 180 $X=1830 $Y=2840
X31 15 clk_b 18 gnd! nmos1v_CDNS_7770859011615 $T=630 1120 0 0 $X=430 $Y=920
X34 clk 15 22 gnd! nmos1v_CDNS_7770859011617 $T=1130 1120 1 180 $X=800 $Y=920
X38 clk_b 13 23 gnd! nmos1v_CDNS_7770859011619 $T=2570 1120 1 180 $X=2240 $Y=920
X39 14 15 gnd! nmos1v_CDNS_7770859011620 $T=1660 1120 0 0 $X=1420 $Y=920
X40 13 clk 14 gnd! nmos1v_CDNS_7770859011621 $T=2160 1120 1 180 $X=1830 $Y=920
X41 clk 13 21 vdd! pmos1v_CDNS_7770859011622 $T=2570 3040 1 180 $X=2240 $Y=2840
X42 rdata0 ren0_b 16 vdd! pmos1v_CDNS_7770859011623 $T=4000 3040 1 180 $X=3490 $Y=2840
X43 rdata0 ren0 24 gnd! nmos1v_CDNS_7770859011624 $T=4000 1120 1 180 $X=3490 $Y=920
X44 rdata1 ren1 25 gnd! nmos1v_CDNS_7770859011624 $T=4740 1120 0 0 $X=4540 $Y=920
X45 rdata1 ren1_b 17 vdd! pmos1v_CDNS_7770859011625 $T=4740 3040 0 0 $X=4540 $Y=2840
X46 12 25 gnd! nmos1v_CDNS_7770859011626 $T=4530 1120 0 0 $X=4290 $Y=920
M0 gnd! 14 22 gnd! g45n1svt L=4.5e-08 W=1.2e-07 AD=1.92e-14 AS=7.2e-15 PD=5.6e-07 PS=3.6e-07 fw=1.2e-07 sa=5.55e-07 sb=1.065e-06 sca=5.43278 scb=0.00141223 scc=3.10179e-06 $X=1250 $Y=1120 $dt=0
M1 gnd! 12 23 gnd! g45n1svt L=4.5e-08 W=1.2e-07 AD=1.92e-14 AS=7.2e-15 PD=5.6e-07 PS=3.6e-07 fw=1.2e-07 sa=1.275e-06 sb=3.45e-07 sca=5.43278 scb=0.00141223 scc=3.10179e-06 $X=2690 $Y=1120 $dt=0
M2 12 13 gnd! gnd! g45n1svt L=4.5e-08 W=1.2e-07 AD=1.68e-14 AS=1.92e-14 PD=5.2e-07 PS=5.6e-07 fw=1.2e-07 sa=1.48e-06 sb=1.4e-07 sca=5.43278 scb=0.00141223 scc=3.10179e-06 $X=3100 $Y=1120 $dt=0
M3 gnd! 12 24 gnd! g45n1svt L=4.5e-08 W=1.2e-07 AD=1.92e-14 AS=7.2e-15 PD=5.6e-07 PS=3.6e-07 fw=1.2e-07 sa=2.45e-07 sb=4.5e-07 sca=5.43278 scb=0.00141223 scc=3.10179e-06 $X=4120 $Y=1120 $dt=0
M4 vdd! 14 19 vdd! g45p1svt L=4.5e-08 W=1.6e-07 AD=2.56e-14 AS=9.6e-15 PD=6.4e-07 PS=4.4e-07 fw=1.6e-07 sa=5.55e-07 sb=1.065e-06 sca=10.9431 scb=0.0104049 scc=0.000358265 $X=1250 $Y=3040 $dt=1
M5 vdd! 12 21 vdd! g45p1svt L=4.5e-08 W=1.6e-07 AD=2.56e-14 AS=9.6e-15 PD=6.4e-07 PS=4.4e-07 fw=1.6e-07 sa=1.275e-06 sb=3.45e-07 sca=10.9431 scb=0.0104049 scc=0.000358265 $X=2690 $Y=3040 $dt=1
.ends RFReg

* +++++++++++++++++++++++++++++++++++++++++++++++++++++++++ *
* Sub cell: RFslice                                         *
* +++++++++++++++++++++++++++++++++++++++++++++++++++++++++ *
.subckt RFslice gnd! rdata0 rdata1 ren0<0> ren0<1> ren0<2> ren0<3> ren0<4> ren0<5> ren0<6>
+ ren0<7> ren0_b<1> ren0_b<2> ren0_b<3> ren0_b<4> ren0_b<5> ren0_b<6> ren0_b<7> ren1<0> ren1<1>
+ ren1<2> ren1<3> ren1<4> ren1<5> ren1<6> ren1<7> ren1_b<1> ren1_b<2> ren1_b<3> ren1_b<4>
+ ren1_b<5> ren1_b<6> ren1_b<7> vdd! wdata wen<1> wen<2> wen<3> wen<4> wen<5>
+ wen<6> wen<7> wen_b<1> wen_b<2> wen_b<3> wen_b<4> wen_b<5> wen_b<6> wen_b<7>
** N=151 EP=49 FDC=192
X50 1 vdd! gnd! 6 inv_x1 $T=44000 0 0 0 $X=43940 $Y=-280
X51 2 vdd! gnd! 7 inv_x1 $T=46000 0 0 0 $X=45940 $Y=-280
X52 1 2 gnd! ren0<0> ren1<0> RFzero $T=0 0 0 0 $X=-60 $Y=-280
X53 rdata0 6 vdd! gnd! inv_x4 $T=45000 0 0 0 $X=44940 $Y=-280
X54 rdata1 7 vdd! gnd! inv_x4 $T=47000 0 0 0 $X=46940 $Y=-280
X55 wdata vdd! gnd! wen<1> wen_b<1> ren0_b<1> ren0<1> 1 ren1<1> ren1_b<1>
+ 2 RFReg $T=2000 0 0 0 $X=1940 $Y=-280
X56 wdata vdd! gnd! wen<2> wen_b<2> ren0_b<2> ren0<2> 1 ren1<2> ren1_b<2>
+ 2 RFReg $T=8000 0 0 0 $X=7940 $Y=-280
X57 wdata vdd! gnd! wen<3> wen_b<3> ren0_b<3> ren0<3> 1 ren1<3> ren1_b<3>
+ 2 RFReg $T=14000 0 0 0 $X=13940 $Y=-280
X58 wdata vdd! gnd! wen<4> wen_b<4> ren0_b<4> ren0<4> 1 ren1<4> ren1_b<4>
+ 2 RFReg $T=20000 0 0 0 $X=19940 $Y=-280
X59 wdata vdd! gnd! wen<5> wen_b<5> ren0_b<5> ren0<5> 1 ren1<5> ren1_b<5>
+ 2 RFReg $T=26000 0 0 0 $X=25940 $Y=-280
X60 wdata vdd! gnd! wen<6> wen_b<6> ren0_b<6> ren0<6> 1 ren1<6> ren1_b<6>
+ 2 RFReg $T=32000 0 0 0 $X=31940 $Y=-280
X61 wdata vdd! gnd! wen<7> wen_b<7> ren0_b<7> ren0<7> 1 ren1<7> ren1_b<7>
+ 2 RFReg $T=38000 0 0 0 $X=37940 $Y=-280
M0 6 1 vdd! vdd! g45p1svt L=4.5e-08 W=1.6e-07 AD=2.24e-14 AS=2.24e-14 PD=6e-07 PS=6e-07 fw=1.6e-07 sa=1.4e-07 sb=1.4e-07 sca=6.2254 scb=0.00172804 scc=3.24157e-06 $X=44360 $Y=3880 $dt=1
M1 rdata0 6 vdd! vdd! g45p1svt L=4.5e-08 W=6.7e-07 AD=9.38e-14 AS=9.38e-14 PD=1.62e-06 PS=1.62e-06 fw=6.7e-07 sa=1.4e-07 sb=1.4e-07 sca=7.30762 scb=0.00381521 scc=4.56892e-05 $X=45360 $Y=3240 $dt=1
M2 7 2 vdd! vdd! g45p1svt L=4.5e-08 W=1.6e-07 AD=2.24e-14 AS=2.24e-14 PD=6e-07 PS=6e-07 fw=1.6e-07 sa=1.4e-07 sb=1.4e-07 sca=6.76591 scb=0.0019224 scc=3.30696e-06 $X=46360 $Y=3880 $dt=1
M3 rdata1 7 vdd! vdd! g45p1svt L=4.5e-08 W=6.7e-07 AD=9.38e-14 AS=9.38e-14 PD=1.62e-06 PS=1.62e-06 fw=6.7e-07 sa=1.4e-07 sb=1.4e-07 sca=16.3208 scb=0.0170889 scc=0.000613172 $X=47360 $Y=3240 $dt=1
.ends RFslice
