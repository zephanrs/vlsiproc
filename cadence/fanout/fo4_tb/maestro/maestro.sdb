ADE simulation setup
Run mode: Single Run, Sweeps and Corners
Tests:
  fanout_fo4_tb_1: fanout/fo4_tb/config, simulator spectre
