ADE simulation setup
Run mode: Single Run, Sweeps and Corners
Tests:
  fanout_ct_tb_1: fanout/ct_tb/config, simulator spectre
