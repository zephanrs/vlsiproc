ADE simulation setup
Test fanout_ct_tb_1: fanout/ct_tb/schematic, simulator spectre
  Models: /opt/cadence-designkits/gpdk045_v_6_0/gpdk045/../models/spectre/gpdk045.scs[mc]
  Temperature: 27
  Analysis tran: stop=10n errpreset=conservative
  Signals: /clk, /a_clk, /addr_clk, /b_clk, /ctrl_clk, /ir_clk, /old_pc, /pc_clk, /rf_clk, /wd_clk
Run mode: Single Run, Sweeps and Corners
