ADE simulation setup
Run mode: Single Run, Sweeps and Corners
Tests:
  fanout_fo4_tb_1: fanout/1t1_tb/config, simulator spectre
