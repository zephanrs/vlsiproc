ADE simulation setup
Test fanout_fo4_tb_1: fanout/fo4_tb/config, simulator spectre
  Models: /opt/cadence-designkits/gpdk045_v_6_0/gpdk045/../models/spectre/gpdk045.scs[mc]
  Temperature: 27
  Analysis tran: stop=10n errpreset=conservative
  Signals: /in, /out
Run mode: Single Run, Sweeps and Corners
