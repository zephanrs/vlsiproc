ADE simulation setup
Run mode: Single Run, Sweeps and Corners
Tests:
  testbenchs_rf_tb_1: testbenchs/rf_simple_tb/schematic, simulator spectre
    Variables: vdd = 1; tclk = 1n
