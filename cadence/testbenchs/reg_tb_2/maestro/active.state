ADE simulation setup
Test testbenchs_reg_tb_2_1: testbenchs/reg_tb_2/schematic, simulator spectre
  Models: /opt/cadence-designkits/gpdk045_v_6_0/gpdk045/../models/spectre/gpdk045.scs[mc]
  Variables: delay = 0, 0.2n; out_pert = 0; reset = 0; set = 0; tdelay = 0; tr = 10p; vdd = 1
  Temperature: 27
  Analysis tran: stop=10n errpreset=conservative
  Signals: /IN<7:0>, /OUT<7:0>, /ck, /ena
Run mode: Single Run, Sweeps and Corners
Setup values for test testbenchs_reg_tb_2_1: reset = 1
