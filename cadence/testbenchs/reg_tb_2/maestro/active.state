ADE simulation setup
Test testbenchs_reg_tb_2_1: testbenchs/reg_tb_2/config, simulator spectre
  Models: /opt/cadence-designkits/gpdk045_v_6_0/gpdk045/../models/spectre/gpdk045.scs[mc]
  Variables: tclk = 1; delay = 0, 0.2n; out_pert = 0; reset = 1; set = 0; tdelay = 0; tr = 10p; vdd = 1
  Temperature: 27
  Analysis tran: stop=20n errpreset=conservative
  Signals: /ck, /ena, /IN<15:0>, /OUT<15:0>
Run mode: Single Run, Sweeps and Corners
