ADE simulation setup
Run mode: Single Run, Sweeps and Corners
Tests:
  testbenchs_reg_tb_2_1: testbenchs/reg_tb_2/config, simulator spectre
    Variables: out_pert = 0; reset = 1; set = 0; tdelay = 0; tr = 10p; vdd = 1; delay = 0, 0.2n; tclk = 1
