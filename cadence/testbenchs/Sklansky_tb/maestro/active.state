ADE simulation setup
Test testbenchs_Adder_tb_1: testbenchs/Adder_tb/schematic, simulator spectre
  Models: /opt/cadence-designkits/gpdk045_v_6_0/gpdk045/../models/spectre/gpdk045.scs[mc]
  Variables: A_in = 255; B_in = 0
  Temperature: 27
  Analysis tran: stop=400p errpreset=conservative
  Signals: /A<7:0>, /B<7:0>, /S<7:0>, /I0/P<7>, /I0/P<6>, /I0/P<5>, /I0/P<4>, /I0/P<3>, /I0/P<2>, /I0/P<1>, /I0/P<0>, /I0/G<7>, /I0/G<6>, /I0/G<5>, /I0/G<4>, /I0/G<3>, /I0/G<2>, /I0/G<1>, /I0/G<0>
Run mode: Single Run, Sweeps and Corners
Setup values for test testbenchs_Adder_tb_1: A_in = 0 0 255 1 2 4 8 16 32 64 128 0 0 0 0 0 0 0 0 1 2 4 8 16 32 64 128 1 3 7 15 31 63 127 255 255 128 255 128 127 170 85 170 85 170 85 128 129 192 127 180 204 150 225 102; B_in = 0 255 0 0 0 0 0 0 0 0 0 1 2 4 8 16 32 64 128 1 2 4 8 16 32 64 128 1 1 1 1 1 1 1 1 255 128 1 127 127 85 170 170 85 1 1 1 129 64 1 77 51 105 31 154
