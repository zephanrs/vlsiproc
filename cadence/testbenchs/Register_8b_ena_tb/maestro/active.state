ADE simulation setup
Test testbenchs_reg_tb_2_1: testbenchs/Register_8b_ena_tb/config, simulator spectre
  Models: /opt/cadence-designkits/gpdk045_v_6_0/gpdk045/../models/spectre/gpdk045.scs[mc]
  Variables: tclk = 500p; vdd = 1
  Temperature: 27
  Analysis tran: stop=100n errpreset=conservative
  Signals: /IN<7:0>, /OUT<7:0>, /ena, /ck, /pwr_mon
Run mode: Single Run, Sweeps and Corners
