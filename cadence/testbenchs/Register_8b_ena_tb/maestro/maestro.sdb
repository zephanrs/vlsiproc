ADE simulation setup
Run mode: Single Run, Sweeps and Corners
Tests:
  testbenchs_reg_tb_2_1: testbenchs/Register_8b_ena_tb/config, simulator spectre
    Variables: vdd = 1; tclk = 500p
