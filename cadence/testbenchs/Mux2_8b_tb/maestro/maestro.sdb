ADE simulation setup
Run mode: Single Run, Sweeps and Corners
Tests:
  testbenchs_Mux2_8b_tb_1: testbenchs/Mux2_8b_tb/config, simulator spectre
    Variables: tclk = 1n
