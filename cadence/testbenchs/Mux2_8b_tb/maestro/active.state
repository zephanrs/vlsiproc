ADE simulation setup
Test testbenchs_Mux2_tb_1: testbenchs/Mux2_8b_tb/config, simulator spectre
  Models: /opt/cadence-designkits/gpdk045_v_6_0/gpdk045/../models/spectre/gpdk045.scs[mc]
  Temperature: 27
  Analysis tran: stop=7n
  Signals: /in0<7:0>, /in1<7:0>, /sel, /net7<0:7>
