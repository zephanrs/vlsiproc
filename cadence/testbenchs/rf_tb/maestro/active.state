ADE simulation setup
Test testbenchs_rf_tb_1: testbenchs/rf_tb/config, simulator spectre
  Models: /opt/cadence-designkits/gpdk045_v_6_0/gpdk045/../models/spectre/gpdk045.scs[mc]
  Variables: vdd = 1; tclk = 1n; tdelay = 150p
  Temperature: 27
  Analysis tran: stop=40n errpreset=conservative
  Signals: /clk, /rf_wen, /waddr<2:0>, /wdata<7:0>, /raddr0<2:0>, /rdata0<7:0>, /raddr1<2:0>, /rdata1<7:0>
Run mode: Single Run, Sweeps and Corners
Setup values for test testbenchs_rf_tb_1: tclk = 500p; tdelay = 250p
