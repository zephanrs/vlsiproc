ADE simulation setup
Run mode: Single Run, Sweeps and Corners
Tests:
  testbenchs_Mux2_tb_1: testbenchs/Mux2_tb/schematic, simulator spectre
    Variables: s1 = 1; s2 = 1,2
