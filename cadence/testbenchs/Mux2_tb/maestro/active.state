ADE simulation setup
Test testbenchs_Mux2_tb_1: testbenchs/Mux2_tb/schematic, simulator spectre
  Models: /opt/cadence-designkits/gpdk045_v_6_0/gpdk045/../models/spectre/gpdk045.scs[mc]
  Variables: s1 = 1; s2 = 1
  Temperature: 27
  Analysis tran: stop=7n
  Signals: /sel, /sel_b, /in1, /in0, /net12
Run mode: Single Run, Sweeps and Corners
