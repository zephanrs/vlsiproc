ADE simulation setup
Test testbenchs_Mux2_tb_1: testbenchs/Mux2_tb/config, simulator spectre
  Models: /opt/cadence-designkits/gpdk045_v_6_0/gpdk045/../models/spectre/gpdk045.scs[mc]
  Temperature: 27
  Analysis tran: stop=7n
  Signals: /sel, /sel_b, /in1, /in0, /f
Run mode: Single Run, Sweeps and Corners
