ADE simulation setup
Test testbenchs_Mux4_tb_1: testbenchs/Comparator_tb/schematic, simulator spectre
  Models: /opt/cadence-designkits/gpdk045_v_6_0/gpdk045/../models/spectre/gpdk045.scs[mc]
  Temperature: 27
  Analysis tran: stop=7n
  Signals: /in0<7:0>, /in1<7:0>, /out
Run mode: Single Run, Sweeps and Corners
