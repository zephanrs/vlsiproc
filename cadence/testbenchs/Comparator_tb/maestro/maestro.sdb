ADE simulation setup
Run mode: Single Run, Sweeps and Corners
Tests:
  testbenchs_Mux4_tb_1: testbenchs/Comparator_tb/schematic, simulator spectre
