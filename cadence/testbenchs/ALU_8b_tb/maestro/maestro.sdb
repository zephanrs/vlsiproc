ADE simulation setup
Run mode: Single Run, Sweeps and Corners
Tests:
  testbenchs_ALU_8b_tb_1: testbenchs/ALU_8b_tb/schematic, simulator spectre
    Variables: tclk = 500p
    Outputs: /sum<7:0>; /eq; /pwr_mon; /in0<7:0>; /in1<7:0>
