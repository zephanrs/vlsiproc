ADE simulation setup
Test testbenchs_ALU_8b_tb_1: testbenchs/ALU_8b_tb/schematic, simulator spectre
  Models: /opt/cadence-designkits/gpdk045_v_6_0/gpdk045/../models/spectre/gpdk045.scs[mc]
  Variables: tclk = 500p
  Temperature: 27
  Analysis tran: stop=100n errpreset=conservative
  Signals: /sum<7:0>, /eq, /pwr_mon, /in0<7:0>, /in1<7:0>
Run mode: Single Run, Sweeps and Corners
