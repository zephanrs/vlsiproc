ADE simulation setup
Run mode: Single Run, Sweeps and Corners
Tests:
  testbenchs_Adder_tb_1: testbenchs/Adder_tb/schematic, simulator spectre
    Variables: A_in = 0 0 255 1 2 4 8 16 32 64 128 0 0 0 0 0 0 0 0 1 2 4 8 16 32 64 128 1 3 7 15 31 63 127 255 255 128 255 128 127 170 85 170 85 170 85 128 129 192 127 180 204 150 225 102; B_in = 0 255 0 0 0 0 0 0 0 0 0 1 2 4 8 16 32 64 128 1 2 4 8 16 32 64 128 1 1 1 1 1 1 1 1 255 128 1 127 127 85 170 170 85 1 1 1 129 64 1 77 51 105 31 154
    Outputs: /A<7:0>; /B<7:0>; /S<7:0>
