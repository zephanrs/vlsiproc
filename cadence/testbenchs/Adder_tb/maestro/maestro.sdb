ADE simulation setup
Run mode: Single Run, Sweeps and Corners
Tests:
  testbenchs_Adder_tb_1: testbenchs/Adder_tb/schematic, simulator spectre
    Variables: A_in = 1; B_in = 1
    Outputs: /A<7:0>; /B<7:0>; /S<7:0>
