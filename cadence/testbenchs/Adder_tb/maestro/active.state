ADE simulation setup
Test testbenchs_Adder_tb_1: testbenchs/Adder_tb/schematic, simulator spectre
  Models: /opt/cadence-designkits/gpdk045_v_6_0/gpdk045/../models/spectre/gpdk045.scs[mc]
  Variables: A_in = 0 255 1 128 127 170 85 128 127 255 127 128 0 1 0 255 254 128 129 1 2 4 8 16 32 64 128 1 0 128 127 255 254 170 85 170 85 171 84 255 0 255 1 128 1 240 241 16 17 192 193 32 16 48 96 160 144 179 63 99 200 17 128 64; B_in = 0 255 1 128 127 170 85 127 128 127 255 0 128 0 1 254 255 129 128 0 0 0 0 0 0 0 0 0 1 127 128 254 255 85 170 84 86 170 85 0 255 1 255 1 128 241 240 17 16 193 192 16 32 32 112 144 160 76 192 99 201 16 129 64
  Temperature: 27
  Analysis tran: stop=400p errpreset=conservative
  Signals: /in0<7:0>, /in1<7:0>, /eq
Run mode: Single Run, Sweeps and Corners
