ADE simulation setup
Test testbenchs_Proc_tb_1: testbenchs/Proc_tb/config, simulator ams
  Models: /opt/cadence-designkits/gpdk045_v_6_0/gpdk045/../models/spectre/gpdk045.scs[mc]
  Variables: vdd = 1
  Temperature: 27
  Analysis tran: stop=100n errpreset=liberal
  Signals: /clk, /rst, /I0/instr<15:0>, /idmem_rdata<15:0>, /idmem_addr<7:0>, /idmem_type, /idmem_val, /idmem_wdata<7:0>, /I0/PC_out<7:0>, /I0/op2_sel<1:0>, /I0/I14/state<3:0>, /I0/wb_sel_out<7:0>, /I0/rdata1_out<7:0>, /I0/rdata0_out<7:0>, /I0/pc_sel_mux_out<7:0>, /I0/pc_old_out<7:0>, /I0/op1_sel_out<7:0>, /I0/mux4_out<7:0>, /I0/alu_out<7:0>, /I0/addr_out<7:0>, /I0/Wsel_out<7:0>, /I0/A_reg_out<7:0>, /I0/proc_a_clk, /I0/proc_addr_clk, /I0/proc_b_clk, /I0/proc_ir_clk, /I0/ab_en, /I0/addr_en, /I0/fetch_en, /I0/pc_en, /I0/rf_wen, /I0/wd_en, /I0/eq, /I0/pc_sel, /I0/addr_sel, /I0/op1_sel, /I0/proc_pc_clk, /I0/proc_pc_old_clk, /I0/proc_rf_clk<7:1>, /I0/proc_wd_clk, /I0/I0/A/net7, /I0/I0/B/net7, /I0/I0/Addr/net7, /I0/I0/WD/net7, /I0/I0/IR/outb_ck_top, /I0/I0/IR/outb_ck_bottom, /I0/I0/PC/net4, /I0/I0/PC_old/net7, /pwr_mon, /I0/I0/net25<0:7>
Run mode: Single Run, Sweeps and Corners
