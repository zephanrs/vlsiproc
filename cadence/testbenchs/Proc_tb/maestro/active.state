ADE simulation setup
Test testbenchs_Proc_tb_1: testbenchs/Proc_tb/config, simulator ams
  Models: /opt/cadence-designkits/gpdk045_v_6_0/gpdk045/../models/spectre/gpdk045.scs[mc]
  Variables: vdd = 1
  Temperature: 27
  Analysis tran: stop=1u
  Signals: /clk, /rst, /I0/instr<15:0>, /idmem_rdata<15:0>, /idmem_addr<7:0>, /idmem_type, /idmem_val, /idmem_wdata<7:0>, /I0/PC_out<7:0>, /I0/op2_sel<1:0>, /I0/I14/state<3:0>, /I0/wb_sel_out<7:0>, /I0/rdata1_out<7:0>
Run mode: Single Run, Sweeps and Corners
