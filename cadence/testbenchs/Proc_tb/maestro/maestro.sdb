ADE simulation setup
Run mode: Single Run, Sweeps and Corners
Tests:
  testbenchs_Proc_tb_1: testbenchs/Proc_tb/config, simulator ams
    Variables: vdd = 1
    Outputs: "/idmem_addr<15:0>"; "/idmem_addr<7:0>"; "/idmem_rdata<15:0>"; /I0/proc_a_clk; /I0/proc_addr_clk; /I0/proc_b_clk; /I0/proc_ir_clk; /I0/proc_pc_clk; /I0/proc_pc_old_clk; /I0/proc_rf_clk<7:1>; /I0/proc_wd_clk; /I0/A/net1; /I0/I0/A/net1; "/I0/I0/A/net1"; /I0/I0/B/net1; /I0/I0/Addr/net1; /I0/I0/WD/net1; /I0/I0/PC/net1; /I0/I0/IR/outb_ck_top; /I0/I0/IR/outb_ck_bottom; /I0/I0/PC/net4; /I0/I0/PC_old/net7; /I0/I0/A/net7; /I0/I0/B/net7; /I0/I0/Addr/net7; /I0/I0/WD/net7
