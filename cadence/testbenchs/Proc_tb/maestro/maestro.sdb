ADE simulation setup
Run mode: Single Run, Sweeps and Corners
Tests:
  testbenchs_Proc_tb_1: testbenchs/Proc_tb/config, simulator ams
    Variables: vdd = 1
    Outputs: "/idmem_addr<15:0>"; "/idmem_addr<7:0>"; "/idmem_rdata<15:0>"
