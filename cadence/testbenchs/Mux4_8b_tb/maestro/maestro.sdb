ADE simulation setup
Run mode: Single Run, Sweeps and Corners
Tests:
  testbenchs_Mux4_tb_1: testbenchs/Mux4_8b_tb/config, simulator spectre
    Variables: tclk = 500p
