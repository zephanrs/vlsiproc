ADE simulation setup
Test testbenchs_Mux4_tb_1: testbenchs/Mux4_8b_tb/config, simulator spectre
  Models: /opt/cadence-designkits/gpdk045_v_6_0/gpdk045/../models/spectre/gpdk045.scs[mc]
  Variables: tclk = 500p
  Temperature: 27
  Analysis tran: stop=100n
  Signals: /in0<7:0>, /in1<7:0>, /in2<7:0>, /in3<7:0>, /sel<1:0>, /out<7:0>, /pwr_mon
Run mode: Single Run, Sweeps and Corners
