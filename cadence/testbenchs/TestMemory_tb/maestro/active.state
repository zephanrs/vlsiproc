ADE simulation setup
Test testbenchs_TestMemory_tb_1: testbenchs/TestMemory_tb/config, simulator ams
  Models: /opt/cadence-designkits/gpdk045_v_6_0/gpdk045/../models/spectre/gpdk045.scs[mc]
  Variables: vdd = 1
  Temperature: 27
  Analysis tran: stop=20n
  Signals: /clk, /rst, /data<15:0>
Run mode: Single Run, Sweeps and Corners
