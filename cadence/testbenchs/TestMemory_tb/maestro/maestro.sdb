ADE simulation setup
Run mode: Single Run, Sweeps and Corners
Tests:
  testbenchs_TestMemory_tb_1: testbenchs/TestMemory_tb/config, simulator ams
    Variables: vdd = 1
