ADE simulation setup
Run mode: Single Run, Sweeps and Corners
Tests:
  testbenchs_ALU_tb_1: testbenchs/ALU_tb/config, simulator spectre
    Variables: A_in = 127; B_in = 1
    Outputs: "/in0<7:0>"; "/in1<7:0>"; /in1<7:0>; /in0<7:0>; "/sum<7:0>"; /eq; /sum<7:0>; /out<7:0>
