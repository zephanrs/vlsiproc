ADE simulation setup
Test testbenchs_ALU_tb_1: testbenchs/ALU_tb/schematic, simulator spectre
  Models: /opt/cadence-designkits/gpdk045_v_6_0/gpdk045/../models/spectre/gpdk045.scs[mc]
  Variables: A_in = 255; B_in = 254
  Temperature: 27
  Analysis tran: stop=400p
  Signals: /in0<7:0>, /in1<7:0>, /out<7:0>, /eq
Run mode: Single Run, Sweeps and Corners
Setup values for test testbenchs_ALU_tb_1: A_in = 127; B_in = 1
