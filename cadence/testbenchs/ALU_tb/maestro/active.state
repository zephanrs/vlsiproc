ADE simulation setup
Test testbenchs_ALU_tb_1: testbenchs/ALU_tb/config, simulator spectre
  Models: /opt/cadence-designkits/gpdk045_v_6_0/gpdk045/../models/spectre/gpdk045.scs[mc]
  Variables: A_in = 127; B_in = 1
  Temperature: 27
  Analysis tran: stop=1n
  Signals: /in0<7:0>, /in1<7:0>, /out<7:0>, /eq, /pwr_mon
Run mode: Single Run, Sweeps and Corners
