ADE simulation setup
Run mode: Single Run, Sweeps and Corners
Tests:
  testbenchs_Mux4_tb_1: testbenchs/Mux4_tb/schematic, simulator spectre
    Variables: s1 = 4; s2 = 2; s3 = 1
