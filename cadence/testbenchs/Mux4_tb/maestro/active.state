ADE simulation setup
Test testbenchs_Mux4_tb_1: testbenchs/Mux4_tb/schematic, simulator spectre
  Models: /opt/cadence-designkits/gpdk045_v_6_0/gpdk045/../models/spectre/gpdk045.scs[mc]
  Variables: s1 = 4; s2 = 2; s3 = 1
  Temperature: 27
  Analysis tran: stop=7n
  Signals: /in0, /in1, /in2, /in3, /sel<1:0>, /out
Run mode: Single Run, Sweeps and Corners
